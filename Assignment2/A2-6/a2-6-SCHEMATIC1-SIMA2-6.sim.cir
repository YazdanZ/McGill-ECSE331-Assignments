** Profile: "SCHEMATIC1-SIMA2-6"  [ D:\School\University\McGill\Course Material\Fourth Semester - Winter 2021\ECSE331\Assignments\Assignments\Assignment2\A2-6\a2-6-SCHEMATIC1-SIMA2-6.sim ]

** Creating circuit file "a2-6-SCHEMATIC1-SIMA2-6.sim.cir"
** WARNING: THIS AUTOMATICALLY GENERATED FILE MAY BE OVERWRITTEN BY SUBSEQUENT SIMULATIONS

*Libraries:
* Local Libraries :
* From [PSPICE NETLIST] section of pspiceev.ini file:
.lib "nom.lib"

*Analysis directives:
.DC LIN V_V1 -10 10 0.01
.PROBE
.INC "a2-6-SCHEMATIC1.net"

.INC "a2-6-SCHEMATIC1.als"

.END
