** Profile: "SCHEMATIC1-SIMA2-3"  [ D:\School\University\McGill\Course Material\Fourth Semester - Winter 2021\ECSE331\Assignments\Assignments\Assignment2\A2-2\A2-3\a2-3-SCHEMATIC1-SIMA2-3.sim ]

** Creating circuit file "a2-3-SCHEMATIC1-SIMA2-3.sim.cir"
** WARNING: THIS AUTOMATICALLY GENERATED FILE MAY BE OVERWRITTEN BY SUBSEQUENT SIMULATIONS

*Libraries:
* Local Libraries :
* From [PSPICE NETLIST] section of pspiceev.ini file:
.lib "nom.lib"

*Analysis directives:
.TRAN  0 0.1s 0
.PROBE
.INC "a2-3-SCHEMATIC1.net"

.INC "a2-3-SCHEMATIC1.als"

.END
